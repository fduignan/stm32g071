| IBIS file stm32g071_081_ufbga64.ibs
[IBIS ver]   4.2
[File name]   stm32g071_081_ufbga64.ibs
[File Rev]   1.0
[Date]   26-11-2018
[Source]   Data Created at STMicroelectronics
[Notes]   File originated from ELDO simulations.
[Disclaimer]  This information is for modeling purpose only and is
   not guaranteed.
   The information is subject to change without notice.
[Copyright]   Copyright 2018 STMicroelectronics Inc.
|   Component stm32g071_081_ufbga64
[Component] stm32g071_081_ufbga64
[Manufacturer] STMicroelectronics
[Package]
| variable   typ   min   max
R_pkg   0.0   0.0   0.0
L_pkg   0.0H   0.0H   0.0H
C_pkg   0.0F   0.0F   0.0F
[Pin]   signal_name   model_name  R_pin L_pin C_pin
A1 PC11 io6_ft
A2 PC10 io6_ft
A3 PB7 io6_i2c_ft
A4 PB6 io6_i2c_ft
A5 PD6 io6_ft
A6 PD2 io6usb
A7 PD0 io6usb
A8 PC8 io6_ft
B1 PC15-OSC32_OUT io8prog2m25m50m120m_sudq_ft
B2 PC12 io6_ft
B3 PB8 io6_i2c_ft
B4 PB3 io6_ft
B5 PD5 io6_ft
B6 PD1 io6_ft
B7 PC9 io6_ft
B8 PA12[PA10] io6_i2c_ft
C1 PC14-OSC32_IN io8prog2m25m50m120m_sudq_ft
C2 PC13 io8prog2m25m50m120m_sudq_ft
C3 PB9 io6_i2c_ft
C4 PB4 io6_ft
C5 PD4 io6_ft
C6 PA15 io6_ft
C7 PA14-BOOT0 io6_ft
C8 PA11[PA9] io6_i2c_ft
D1 VDD/VDDA POWER
D2 VREF+ POWER
D3 VBAT POWER
D4 PB5 io6_ft
D5 PD3 io6_ft
D6 PA10 io6_i2c_ft
D7 PA13 io6_ft
D8 PD9 io6_ft
E1 VSS/VSSA GND
E2 PF2-NRST io6reset
E3 PC0 io6_ft
E4 PA7 io6_ft
E5 PC7 io6_ft
E6 PA9 io6_i2c_ft
E7 PC6 io6_ft
E8 PD8 io6_ft
F1 PF0-OSC_IN io6_ft
F2 PC1 io6_ft
F3 PA3 io6_ft
F4 PA6 io6_ft
F5 PB0 io6_ft
F6 PB14 io6_i2c_ft
F7 PB15 io6usb
F8 PA8 io6usb
G1 PF1-OSC_OUT io6_ft
G2 PC2 io6_ft
G3 PA2 io6_ft
G4 PA5 io6_ft
G5 PB1 io6_ft
G6 PB10 io6_i2c_ft
G7 PB12 io6_ft
G8 PB13 io6_i2c_ft
H1 PC3 io6_ft
H2 PA0 io6_ft
H3 PA1 io6_ft
H4 PA4 io6_ft
H5 PC4 io6_ft
H6 PC5 io6_ft
H7 PB2 io6_ft
H8 PB11 io6_i2c_ft
[Model Selector] io8prog2m25m50m120m_sudq_ft
iols8p_sudq_ft_pd_lv  "IO low speed, PD=40kOhm - 1P8V"
iols8p_sudq_ft_pu_lv  "IO low speed, PU=40kOhm - 1P8V"
iols8p_sudq_ft_lv  "IO low speed - 1P8V"
iols8p_sudq_ft_pd  "IO low speed, PD=40kOhm - 3P3V"
iols8p_sudq_ft_pu  "IO low speed, PU=40kOhm - 3P3V"
iols8p_sudq_ft  "IO low speed - 3P3V"
iofs8p_sudq_ft_pd_lv  "IO full speed, PD=40kOhm - 1P8V"
iofs8p_sudq_ft_pu_lv  "IO full speed, PU=40kOhm - 1P8V"
iofs8p_sudq_ft_lv  "IO full speed - 1P8V"
iofs8p_sudq_ft_pd  "IO full speed, PD=40kOhm - 3P3V"
iofs8p_sudq_ft_pu  "IO full speed, PU=40kOhm - 3P3V"
iofs8p_sudq_ft  "IO full speed - 3P3V"
ioms8p_sudq_ft_pd_lv  "IO medium speed, PD=40kOhm - 1P8V"
ioms8p_sudq_ft_pu_lv  "IO medium speed, PU=40kOhm - 1P8V"
ioms8p_sudq_ft_lv  "IO medium speed - 1P8V"
ioms8p_sudq_ft_pd  "IO medium speed, PD=40kOhm - 3P3V"
ioms8p_sudq_ft_pu  "IO medium speed, PU=40kOhm - 3P3V"
ioms8p_sudq_ft  "IO medium speed - 3P3V"
iohs8p_sudq_ft_pd_lv  "IO high speed, PD=40kOhm - 1P8V"
iohs8p_sudq_ft_pu_lv  "IO high speed, PU=40kOhm - 1P8V"
iohs8p_sudq_ft_lv  "IO high speed - 1P8V"
iohs8p_sudq_ft_pd  "IO high speed, PD=40kOhm - 3P3V"
iohs8p_sudq_ft_pu  "IO high speed, PU=40kOhm - 3P3V"
iohs8p_sudq_ft  "IO high speed - 3P3V"
[Model Selector] io6_ft
io6_ft_1v8_highspeed_pd  "GPIO-1.8V range - high speed - pull down"
io6_ft_1v8_fastspeed_pd  "GPIO-1.8V range - fast speed - pull down"
io6_ft_1v8_mediumspeed_pd  "GPIO-1.8V range - medium speed - pull down"
io6_ft_1v8_lowspeed_pd  "GPIO-1.8V range - low speed - pull down"
io6_ft_1v8_highspeed_pu  "GPIO-1.8V range - high speed - pull up"
io6_ft_1v8_fastspeed_pu  "GPIO-1.8V range - fast speed - pull up"
io6_ft_1v8_mediumspeed_pu  "GPIO-1.8V range - medium speed - pull up"
io6_ft_1v8_lowspeed_pu  "GPIO-1.8V range - low speed - pull up"
io6_ft_1v8_highspeed  "GPIO-1.8V range - high speed"
io6_ft_1v8_fastspeed  "GPIO-1.8V range - fast speed"
io6_ft_1v8_mediumspeed  "GPIO-1.8V range - medium speed"
io6_ft_1v8_lowspeed  "GPIO-1.8V range - low speed"
io6_ft_3v3_highspeed_pd  "GPIO-3.3V range - high speed - pull down"
io6_ft_3v3_fastspeed_pd  "GPIO-3.3V range - fast speed - pull down"
io6_ft_3v3_mediumspeed_pd  "GPIO-3.3V range - medium speed - pull down"
io6_ft_3v3_lowspeed_pd  "GPIO-3.3V range - low speed - pull down"
io6_ft_3v3_highspeed_pu  "GPIO-3.3V range - high speed - pull up"
io6_ft_3v3_fastspeed_pu  "GPIO-3.3V range - fast speed - pull up"
io6_ft_3v3_mediumspeed_pu  "GPIO-3.3V range - medium speed - pull up"
io6_ft_3v3_lowspeed_pu  "GPIO-3.3V range - low speed - pull up"
io6_ft_3v3_highspeed  "GPIO-3.3V range - high speed"
io6_ft_3v3_fastspeed  "GPIO-3.3V range - fast speed"
io6_ft_3v3_mediumspeed  "GPIO-3.3V range - medium speed"
io6_ft_3v3_lowspeed  "GPIO-3.3V range - low speed"
[Model Selector] io6_i2c_ft
io6_ft_1v8_highspeed_pd  "GPIO-1.8V range - high speed - pull down"
io6_ft_1v8_fastspeed_pd  "GPIO-1.8V range - fast speed - pull down"
io6_ft_1v8_mediumspeed_pd  "GPIO-1.8V range - medium speed - pull down"
io6_ft_1v8_lowspeed_pd  "GPIO-1.8V range - low speed - pull down"
io6_ft_1v8_highspeed_pu  "GPIO-1.8V range - high speed - pull up"
io6_ft_1v8_fastspeed_pu  "GPIO-1.8V range - fast speed - pull up"
io6_ft_1v8_mediumspeed_pu  "GPIO-1.8V range - medium speed - pull up"
io6_ft_1v8_lowspeed_pu  "GPIO-1.8V range - low speed - pull up"
io6_ft_1v8_highspeed  "GPIO-1.8V range - high speed"
io6_ft_1v8_fastspeed  "GPIO-1.8V range - fast speed"
io6_ft_1v8_mediumspeed  "GPIO-1.8V range - medium speed"
io6_ft_1v8_lowspeed  "GPIO-1.8V range - low speed"
io6_ft_3v3_highspeed_pd  "GPIO-3.3V range - high speed - pull down"
io6_ft_3v3_fastspeed_pd  "GPIO-3.3V range - fast speed - pull down"
io6_ft_3v3_mediumspeed_pd  "GPIO-3.3V range - medium speed - pull down"
io6_ft_3v3_lowspeed_pd  "GPIO-3.3V range - low speed - pull down"
io6_ft_3v3_highspeed_pu  "GPIO-3.3V range - high speed - pull up"
io6_ft_3v3_fastspeed_pu  "GPIO-3.3V range - fast speed - pull up"
io6_ft_3v3_mediumspeed_pu  "GPIO-3.3V range - medium speed - pull up"
io6_ft_3v3_lowspeed_pu  "GPIO-3.3V range - low speed - pull up"
io6_ft_3v3_highspeed  "GPIO-3.3V range - high speed"
io6_ft_3v3_fastspeed  "GPIO-3.3V range - fast speed"
io6_ft_3v3_mediumspeed  "GPIO-3.3V range - medium speed"
io6_ft_3v3_lowspeed  "GPIO-3.3V range - low speed"
io6_i2c_ft_1v8_pd  "GPIO-1.8V I2C functionality - pull down"
io6_i2c_ft_3v3_pd  "GPIO-3.3V I2C functionality - pull down"
io6_i2c_ft_1v8_pu  "GPIO-1.8V I2C functionality - pull up"
io6_i2c_ft_3v3_pu  "GPIO-3.3V I2C functionality pull up"
io6_i2c_ft_1v8  "GPIO-1.8V I2C functionality"
io6_i2c_ft_3v3  "GPIO-3.3V I2C functionality"
[Model Selector] io6usb
io6_ft_1v8_highspeed_pd  "GPIO-1.8V range - high speed - pull down"
io6_ft_1v8_fastspeed_pd  "GPIO-1.8V range - fast speed - pull down"
io6_ft_1v8_mediumspeed_pd  "GPIO-1.8V range - medium speed - pull down"
io6_ft_1v8_lowspeed_pd  "GPIO-1.8V range - low speed - pull down"
io6_ft_1v8_highspeed_pu  "GPIO-1.8V range - high speed - pull up"
io6_ft_1v8_fastspeed_pu  "GPIO-1.8V range - fast speed - pull up"
io6_ft_1v8_mediumspeed_pu  "GPIO-1.8V range - medium speed - pull up"
io6_ft_1v8_lowspeed_pu  "GPIO-1.8V range - low speed - pull up"
io6_ft_1v8_highspeed  "GPIO-1.8V range - high speed"
io6_ft_1v8_fastspeed  "GPIO-1.8V range - fast speed"
io6_ft_1v8_mediumspeed  "GPIO-1.8V range - medium speed"
io6_ft_1v8_lowspeed  "GPIO-1.8V range - low speed"
io6_ft_3v3_highspeed_pd  "GPIO-3.3V range - high speed - pull down"
io6_ft_3v3_fastspeed_pd  "GPIO-3.3V range - fast speed - pull down"
io6_ft_3v3_mediumspeed_pd  "GPIO-3.3V range - medium speed - pull down"
io6_ft_3v3_lowspeed_pd  "GPIO-3.3V range - low speed - pull down"
io6_ft_3v3_highspeed_pu  "GPIO-3.3V range - high speed - pull up"
io6_ft_3v3_fastspeed_pu  "GPIO-3.3V range - fast speed - pull up"
io6_ft_3v3_mediumspeed_pu  "GPIO-3.3V range - medium speed - pull up"
io6_ft_3v3_lowspeed_pu  "GPIO-3.3V range - low speed - pull up"
io6_ft_3v3_highspeed  "GPIO-3.3V range - high speed"
io6_ft_3v3_fastspeed  "GPIO-3.3V range - fast speed"
io6_ft_3v3_mediumspeed  "GPIO-3.3V range - medium speed"
io6_ft_3v3_lowspeed  "GPIO-3.3V range - low speed"
usb_ls_pd  "USB Low Speed mode - Pull Down"
usb_ls_pu2  "USB Low Speed mode - Pull up 2"
usb_ls_pu  "USB Low Speed mode - Pull up"
usb_fs  "USB Low Speed mode"
usb_fs_pd  "USB Full Speed mode - Pull Down"
usb_fs_pu2  "USB Full Speed mode - Pull up 2"
usb_fs_pu  "USB Full Speed mode - Pull up"
[Model Selector] io6reset
io6_ft_1v8_highspeed_pd  "GPIO-1.8V range - high speed - pull down"
io6_ft_1v8_fastspeed_pd  "GPIO-1.8V range - fast speed - pull down"
io6_ft_1v8_mediumspeed_pd  "GPIO-1.8V range - medium speed - pull down"
io6_ft_1v8_lowspeed_pd  "GPIO-1.8V range - low speed - pull down"
io6_ft_1v8_highspeed_pu  "GPIO-1.8V range - high speed - pull up"
io6_ft_1v8_fastspeed_pu  "GPIO-1.8V range - fast speed - pull up"
io6_ft_1v8_mediumspeed_pu  "GPIO-1.8V range - medium speed - pull up"
io6_ft_1v8_lowspeed_pu  "GPIO-1.8V range - low speed - pull up"
io6_ft_1v8_highspeed  "GPIO-1.8V range - high speed"
io6_ft_1v8_fastspeed  "GPIO-1.8V range - fast speed"
io6_ft_1v8_mediumspeed  "GPIO-1.8V range - medium speed"
io6_ft_1v8_lowspeed  "GPIO-1.8V range - low speed"
io6_ft_3v3_highspeed_pd  "GPIO-3.3V range - high speed - pull down"
io6_ft_3v3_fastspeed_pd  "GPIO-3.3V range - fast speed - pull down"
io6_ft_3v3_mediumspeed_pd  "GPIO-3.3V range - medium speed - pull down"
io6_ft_3v3_lowspeed_pd  "GPIO-3.3V range - low speed - pull down"
io6_ft_3v3_highspeed_pu  "GPIO-3.3V range - high speed - pull up"
io6_ft_3v3_fastspeed_pu  "GPIO-3.3V range - fast speed - pull up"
io6_ft_3v3_mediumspeed_pu  "GPIO-3.3V range - medium speed - pull up"
io6_ft_3v3_lowspeed_pu  "GPIO-3.3V range - low speed - pull up"
io6_ft_3v3_highspeed  "GPIO-3.3V range - high speed"
io6_ft_3v3_fastspeed  "GPIO-3.3V range - fast speed"
io6_ft_3v3_mediumspeed  "GPIO-3.3V range - medium speed"
io6_ft_3v3_lowspeed  "GPIO-3.3V range - low speed"
ioreset_1v2_pu  "RESET 1.2V range with PU"
ioreset_1v2  "RESET 1.2V range"
ioreset_1v8_pu  "RESET 1.8V range with PU"
ioreset_1v8  "RESET 1.8V range"
ioreset_3v3_pu  "RESET 3.3V range with PU"
ioreset_3v3  "RESET 3.3V range"
| Models and submodels in the file (67): iols8p_sudq_ft_pd_lv (I/O), iols8p_sudq_ft_pu_lv (I/O), iols8p_sudq_ft_lv (I/O), iols8p_sudq_ft_pd (I/O), iols8p_sudq_ft_pu (I/O), iols8p_sudq_ft (I/O), iofs8p_sudq_ft_pd_lv (I/O), iofs8p_sudq_ft_pu_lv (I/O), iofs8p_sudq_ft_lv (I/O), iofs8p_sudq_ft_pd (I/O), iofs8p_sudq_ft_pu (I/O), iofs8p_sudq_ft (I/O), ioms8p_sudq_ft_pd_lv (I/O), ioms8p_sudq_ft_pu_lv (I/O), ioms8p_sudq_ft_lv (I/O), ioms8p_sudq_ft_pd (I/O), ioms8p_sudq_ft_pu (I/O), ioms8p_sudq_ft (I/O), iohs8p_sudq_ft_pd_lv (I/O), iohs8p_sudq_ft_pu_lv (I/O), iohs8p_sudq_ft_lv (I/O), iohs8p_sudq_ft_pd (I/O), iohs8p_sudq_ft_pu (I/O), iohs8p_sudq_ft (I/O), io6_ft_1v8_highspeed_pd (I/O), io6_ft_1v8_fastspeed_pd (I/O), io6_ft_1v8_mediumspeed_pd (I/O), io6_ft_1v8_lowspeed_pd (I/O), io6_ft_1v8_highspeed_pu (I/O), io6_ft_1v8_fastspeed_pu (I/O), io6_ft_1v8_mediumspeed_pu (I/O), io6_ft_1v8_lowspeed_pu (I/O), io6_ft_1v8_highspeed (I/O), io6_ft_1v8_fastspeed (I/O), io6_ft_1v8_mediumspeed (I/O), io6_ft_1v8_lowspeed (I/O), io6_ft_3v3_highspeed_pd (I/O), io6_ft_3v3_fastspeed_pd (I/O), io6_ft_3v3_mediumspeed_pd (I/O), io6_ft_3v3_lowspeed_pd (I/O), io6_ft_3v3_highspeed_pu (I/O), io6_ft_3v3_fastspeed_pu (I/O), io6_ft_3v3_mediumspeed_pu (I/O), io6_ft_3v3_lowspeed_pu (I/O), io6_ft_3v3_highspeed (I/O), io6_ft_3v3_fastspeed (I/O), io6_ft_3v3_mediumspeed (I/O), io6_ft_3v3_lowspeed (I/O), io6_i2c_ft_1v8_pd (I/O_open_drain), io6_i2c_ft_3v3_pd (I/O_open_drain), io6_i2c_ft_1v8_pu (I/O_open_drain), io6_i2c_ft_3v3_pu (I/O_open_drain), io6_i2c_ft_1v8 (I/O_open_drain), io6_i2c_ft_3v3 (I/O_open_drain), usb_ls_pd (I/O), usb_ls_pu2 (I/O), usb_ls_pu (I/O), usb_fs (I/O), usb_fs_pd (I/O), usb_fs_pu2 (I/O), usb_fs_pu (I/O), ioreset_1v2_pu (I/O_open_drain), ioreset_1v2 (I/O_open_drain), ioreset_1v8_pu (I/O_open_drain), ioreset_1v8 (I/O_open_drain), ioreset_3v3_pu (I/O_open_drain), ioreset_3v3 (I/O_open_drain)
